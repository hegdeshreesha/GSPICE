4-Tone Harmonic Balance Test
V1 1 0 1.5
R1 1 2 50
C1 2 0 1p
D1 2 0
.HB 1G 1.2G 1.5G 1.8G 2
.end
