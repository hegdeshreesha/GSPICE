RC Filter AC Analysis
V1 in 0 5
R1 in out 1k
C1 out 0 1u
.ac dec 5 1 1meg
