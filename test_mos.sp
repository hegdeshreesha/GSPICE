NMOS Amplifier Test
Vdd vdd 0 1.8
Vin in 0 0.8
M1 out in 0 0 NMOS W=10u L=0.18u
Rload vdd out 10k
.op
