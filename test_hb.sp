HB Prototype Test
V1 in 0 5
R1 in 0 1k
.hb 1G 5
