S-Parameter Test
V1 1 0 1
R1 1 2 50
S1 2 3 file="../dummy.s2p"
R2 3 0 50
.AC dec 10 1G 2G
.end
