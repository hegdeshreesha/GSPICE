RF Lowpass Filter
P1 in 0 1 50
R1 in out 10
C1 out 0 1p
P2 out 0 2 50
.sp dec 10 1G 10G
