LC Filter Test
V1 in 0 5
L1 in out 1u
C1 out 0 1u
Rload out 0 50
.ac dec 10 1k 10meg
