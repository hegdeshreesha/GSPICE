* Two-port resistor network S-parameter smoke deck.
P1 in 0 1 50
P2 out 0 2 50
R1 in out 100
R2 in 0 100
R3 out 0 100
.SP DEC 2 1k 10k
.END
