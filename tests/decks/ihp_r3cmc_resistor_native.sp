* IHP SG13G2 r3_cmc resistor wrapper, first-order sheet-resistance support.
.LIB "C:/EDA/LumenCircuitStudio/external/ihp_pdk/ihp-sg13g2/libs.tech/ngspice/models/cornerRES.lib" res_typ
V1 in 0 DC 1
XR1 in 0 0 rsil l=1u w=1u m=1
.OP
.END
