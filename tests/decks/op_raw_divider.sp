OP RAW divider regression
V1 vdd 0 DC 1.8
R1 vdd out 1k
R2 out 0 1k
.OP
.SAVE ALL
.END
