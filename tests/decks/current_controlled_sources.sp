Current-controlled source regression
V1 in 0 DC 1
RIN in 0 1k
F1 0 out V1 2
R1 out 0 1k
H1 hout 0 V1 1k
R2 hout 0 10k
.OP
.END
