* Artifact terminal count must match N-device arity.
.GSDI "../../build/gmc_va_probe.gsdi"
.MODEL probe va_probe G=2m Cj=3p
N1 out mid 0 probe
.OP
.END
