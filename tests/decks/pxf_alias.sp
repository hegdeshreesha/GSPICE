* PXF/PSSXF alias smoke: periodic transfer maps onto PAC.
V1 in 0 SIN(0 1 1k) AC 1
R1 in out 1k
C1 out 0 1n
.PXF V(out) 1k LIN 1 1k 1k SIDEBANDS=1
.END
