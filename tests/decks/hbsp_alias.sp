* HBSP alias smoke: solves S-parameters through the periodic conversion matrix.
P1 in 0 1 50
R1 in 0 50
.HBSP 1k LIN 1 1k 1k SIGNOFF=YES
.END
