* Bad GSDI artifact must fail before model registration.
.GSDI "bad_envelope.gsdi"
.OP
.END
