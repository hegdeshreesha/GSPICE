Corner and production spec regression
V1 in 0 DC 1
R1 in out 1k
R2 out 0 1k
.SPEC vout V(out) MIN=0.44 MAX=0.56
.CORNER low V1=0.9
.CORNER high V1=1.1
.END
