Controlled source regression
V1 in 0 DC 1
G1 0 out in 0 1m
R1 out 0 1k
E1 buf 0 out 0 2
R2 buf 0 10k
.OP
.END
