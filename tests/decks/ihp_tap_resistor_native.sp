* IHP SG13G2 simple tap resistor wrapper.
.include "C:/EDA/LumenCircuitStudio/external/ihp_pdk/ihp-sg13g2/libs.tech/ngspice/models/resistors_mod.lib"
V1 in 0 DC 1
XR1 in 0 ptap1
.OP
.END
