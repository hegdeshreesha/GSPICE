* GSDI manifests declare the accepted compact-model parameters.
.GSDI "../../build/gmc_va_probe.gsdi"
.MODEL probe va_probe BadGain=2m
N1 out 0 probe
V1 out 0 DC 1
.OP
.END
