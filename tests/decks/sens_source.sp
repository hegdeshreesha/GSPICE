DC sensitivity regression
V1 in 0 DC 1
R1 in out 1k
R2 out 0 1k
.SENS V(out) V1
.END
