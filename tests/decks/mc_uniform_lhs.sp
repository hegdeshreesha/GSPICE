* Deterministic Latin-hypercube uniform Monte Carlo smoke deck
V1 out 0 0
R1 out 0 1k
.MC 12 V1 UNIFORM(0, 1) SEED=17 LHS=1
.END
