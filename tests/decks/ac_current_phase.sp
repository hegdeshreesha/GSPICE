* AC current-source phase regression
I1 out 0 DC 0 AC 1 90
R1 out 0 1k
.SAVE V(out)
.AC LIN 1 1k 1k
.END
