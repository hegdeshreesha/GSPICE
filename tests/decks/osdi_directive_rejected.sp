* Legacy OSDI/OpenVAF artifacts must not be accepted in the native path.
.OSDI "psp103.osdi"
.OP
.END
