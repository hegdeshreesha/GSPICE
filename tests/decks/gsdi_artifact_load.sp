* Native GSDI artifact manifest load smoke deck.
.GSDI "../../build/gmc_va_probe.gsdi"
.OP
.END
