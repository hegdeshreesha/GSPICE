Grounded transmission line one-section approximation smoke
V1 src 0 DC 1
RS src in 50
T1 in 0 out 0 Z0=50 TD=1n
RL out 0 50
.END
