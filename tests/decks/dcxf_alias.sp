* DCXF alias smoke
V1 in 0 DC 1 AC 1
R1 in out 1k
R2 out 0 1k
.DCXF V(out)
.END
