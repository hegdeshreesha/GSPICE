* Optional SuiteSparse/KLU backend smoke deck
.OPTIONS SOLVER=KLU ORDERING=NATURAL SINGLETONS=0
V1 in 0 DC 1
R1 in out 1k
R2 out 0 2k
.OP
.END
