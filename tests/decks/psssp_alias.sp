* PSSSP alias smoke: PSS orbit feeds periodic S-parameter conversion.
P1 in 0 1 50
R1 in 0 50
.PSSSP 1k LIN 1 1k 1k
.END
