Unsupported active element must fail
V1 in 0 1
T1 in 0 out 0 Z0=50 TD=1n
.OP
.END
