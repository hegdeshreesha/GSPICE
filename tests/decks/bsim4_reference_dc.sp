* BSIM4 DC reference deck; expected Id(Vg) generated by tools/bsim4_reference_oracle.py
* (faithful BSIM4.8.3 transcription -- ngspice's bundled BSIM4 ignores
*  PDIBL1/PDIBL2/ETAB, so it cannot serve as the reference).
.model NREF nmos level=54 vth0=0.40 u0=500 toxe=10n k1=0 k2=0 dvt0=0 dvt1=0.53 dvt2=-0.032
+ xj=0.15u ua=2.0e-9 ub=5.0e-19 vsat=1.0e5
VDS d 0 0.80
VGS g 0 0
M1 d g 0 0 NREF W=1u L=1u
.dc VGS 0 1 0.1
.print dc v(g) i(VDS)
.end
