* LIB section smoke deck
V1 out 0 1
.LIB "models/corners.lib" fast
.OP
.TRAN 1n 2n
.END
