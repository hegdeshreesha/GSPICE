STEP operating point regression
V1 in 0 DC 0
R1 in out 1k
R2 out 0 1k
.STEP V1 0 1 1
.END
