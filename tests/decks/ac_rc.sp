* AC breadth regression: LIN sweep and summary reporting
V1 in 0 DC 0 AC 1
R1 in out 1k
C1 out 0 1p
.SAVE V(out)
.AC LIN 5 1k 5k
.END
