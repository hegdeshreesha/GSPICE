Behavioral current source regression
V1 in 0 DC 1
B1 in out I={V(in,out)/1k}
R1 out 0 1k
.OP
.END
