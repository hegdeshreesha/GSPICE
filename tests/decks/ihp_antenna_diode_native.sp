* IHP SG13G2 antenna diode wrapper.
.include "C:/EDA/LumenCircuitStudio/external/ihp_pdk/ihp-sg13g2/libs.tech/ngspice/models/diodes.lib"
V1 in 0 DC 0.7
XD1 in 0 dantenna l=780n w=780n
.OP
.END
