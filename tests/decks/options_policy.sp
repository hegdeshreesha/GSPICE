Numerical policy preset regression
.OPTIONS ACCURACY=HIGH NUMERICAL=ROBUST SOLVER=AUTO ORDERING=AMD
V1 in 0 DC 1
R1 in out 1k
R2 out 0 1k
.OP
.END
