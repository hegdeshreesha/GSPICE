* IHP SG13G2 MIM capacitor mismatch corner, deterministic nominal gauss support.
.LIB "C:/EDA/LumenCircuitStudio/external/ihp_pdk/ihp-sg13g2/libs.tech/ngspice/models/cornerCAP.lib" cap_typ_mismatch
V1 in 0 DC 1
XC1 in 0 cap_cmim l=7u w=7u mm_ok=1
.OP
.END
