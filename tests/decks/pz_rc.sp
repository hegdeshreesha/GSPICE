Pole estimate RC regression
V1 in 0 DC 0 AC 1
R1 in out 1k
C1 out 0 1u
.PZ V(out) V1 DEC 20 1 1meg
.END
