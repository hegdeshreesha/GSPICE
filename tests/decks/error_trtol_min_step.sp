* A malformed sub-unity TRTOL must fail instead of crawling at MINSTEP.
V1 in 0 SIN(0 1 200Meg)
R1 in out 1
C1 out 0 1n
.OPTIONS METHOD=BDF MAXORD=1 ADAPTIVE=1 LTE_MODE=PREDICTOR LTE_AUDIT_INTERVAL=0 LTE_RELTOL=1e-12 TRABSTOL=1e-15 TRTOL=1e-12 MINSTEP=1p
.TRAN 1n 10n 0 1n
.END
