Resistor output noise regression
V1 in 0 DC 0 AC 0
R1 in out 1k
R2 out 0 1k
.NOISE V(out) V1 DEC 1 1 10
.END
