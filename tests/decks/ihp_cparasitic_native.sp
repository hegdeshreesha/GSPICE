* IHP SG13G2 parasitic capacitor wrapper.
.include "C:/EDA/LumenCircuitStudio/external/ihp_pdk/ihp-sg13g2/libs.tech/ngspice/models/capacitors_mod.lib"
V1 in 0 DC 1
XC1 in 0 cparasitic c=1p cap_cpara=1
.OP
.END
