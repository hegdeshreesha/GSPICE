Behavioral voltage source regression
V1 in 0 DC 0.7
B1 out 0 V={2*V(in)}
R1 out 0 1k
.OP
.END
