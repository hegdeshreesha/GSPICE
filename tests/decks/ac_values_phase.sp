* AC explicit values and source phase regression
V1 in 0 DC 0 AC 1 90
R1 in out 1k
C1 out 0 1p
.SAVE V(out)
.AC VALUES 1k 2k 5k
.END
