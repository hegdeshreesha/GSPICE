* Native JUNCAP2 ideal+SRH parser/DAE smoke test
.model J2 JUNCAP2 PHITD=0.026 IDSAT=1e-14 CSRH=0
V1 in 0 0.15
D1 in 0 J2
.op
.end
