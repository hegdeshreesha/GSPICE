* IHP SG13G2 bondpad placeholder wrapper.
.include "C:/EDA/LumenCircuitStudio/external/ihp_pdk/ihp-sg13g2/libs.tech/ngspice/models/sg13g2_bondpad.lib"
VPAD pad 0 DC 0
XPAD pad bondpad size=80u
.OP
.END
