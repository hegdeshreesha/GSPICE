* End-to-end GSDI manifest + built-in GMC evaluator smoke deck.
.GSDI "../../build/gmc_va_probe.gsdi"
.MODEL probe va_probe G=2m Cj=3p
N1 out 0 probe
V1 out 0 DC 1
.OP
.END
