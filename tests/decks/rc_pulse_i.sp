* Current PULSE transient smoke deck
I1 in 0 PULSE(0 1m 0 1n 1n 5n 10n)
R1 in 0 1k
C1 in 0 1p
.TRAN 1n 20n
.END
