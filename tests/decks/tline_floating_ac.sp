Floating transmission line one-section approximation smoke
V1 psrc nsrc DC 0 AC 1
RS psrc pin 50
RRET nsrc nin 1m
T1 pin nin pout nout Z0=50 TD=1n
RL pout nout 50
.AC LIN 1 1meg 1meg
.END
