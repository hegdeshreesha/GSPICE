Nested DC sweep regression
V1 in 0 DC 0
V2 bias 0 DC 0
R1 in out 1k
R2 out bias 1k
.DC V1 0 1 1 V2 0 1 1
.END
