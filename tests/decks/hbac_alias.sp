* HBAC alias smoke: native HB-refined orbit feeds periodic conversion.
V1 in 0 DC 0 AC 1
R1 in out 1k
C1 out 0 1n
.HBAC 1k DEC 1 1k 1k
.END
