* Multi-tone HB smoke: commensurate tones solved over a common shooting period.
V1 in 0 SIN(0 1 1k)
I1 out 0 SIN(0 1m 1.5k)
R1 in out 1k
C1 out 0 1n
.HB 1k 1.5k NHARMS=1
.END
