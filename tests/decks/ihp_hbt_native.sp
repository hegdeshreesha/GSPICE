* IHP SG13G2 HBT wrapper, first-pass BJT parser support.
.LIB "C:/EDA/LumenCircuitStudio/external/ihp_pdk/ihp-sg13g2/libs.tech/ngspice/models/cornerHBT.lib" hbt_typ
VC c 0 DC 1
VB b 0 DC 0.8
XQ1 c b 0 0 npn13G2 Nx=1
.OP
.END
