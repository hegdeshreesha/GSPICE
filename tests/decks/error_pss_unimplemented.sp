* PSS must fail rather than reporting convergence from a stub
V1 out 0 SIN(0 1 1k)
R1 out 0 1k
.PSS 1k 5
.END
