* PSS should no longer be a fake unimplemented success path.
V1 out 0 SIN(0 1 1k)
R1 out 0 1k
.PSS 1k 5
.END
