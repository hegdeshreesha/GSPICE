Monte Carlo source regression
V1 in 0 DC 1
R1 in out 1k
R2 out 0 1k
.MC 3 V1 GAUSS(1 0) SEED=7
.END
