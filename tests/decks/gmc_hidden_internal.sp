* GMC generated hidden-node model end-to-end: internal node Td (own MNA
* column), collapsible node Tint -> s (merged into source/ground).
.model psp1 psp_like (Rd=100 KP=2m Cj=3p)
NPSP1 1 2 0 0 psp1
VDD 1 0 5
VGG 2 0 1
.op
.end
