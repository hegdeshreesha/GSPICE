* One-port matched load S-parameter smoke deck.
P1 in 0 1 50
R1 in 0 50
.SP LIN 1 1k 1k
.END
