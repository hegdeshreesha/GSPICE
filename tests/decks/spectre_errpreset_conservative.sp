* Spectre-compatible accuracy alias smoke.
.OPTIONS ERRPRESET=CONSERVATIVE
V1 out 0 1
R1 out 0 1k
.OP
.END
