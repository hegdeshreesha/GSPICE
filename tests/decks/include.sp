* Relative include smoke deck
V1 out 0 1
.INCLUDE "models/load.inc"
.OP
.TRAN 1n 2n
.END
