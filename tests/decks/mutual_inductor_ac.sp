Mutual inductor AC coupling regression
V1 src 0 DC 0 AC 1
RSRC src in 1
L1 in 0 1m
L2 out 0 1m
RLOAD out 0 1k
K1 L1 L2 0.5
.AC LIN 1 1k 1k
.END
