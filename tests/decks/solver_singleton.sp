* Solver singleton reduction smoke deck
.OPTIONS SOLVER=INTERNAL ORDERING=AUTO SINGLETONS=1
V1 in 0 DC 1
R1 in out 1k
R2 out 0 2k
.OP
.END
