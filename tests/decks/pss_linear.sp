* PSS small-signal periodic operating-point smoke deck.
V1 in 0 DC 0 AC 1
R1 in out 1k
C1 out 0 1n
.SAVE V(out)
.PSS 1k 1
.END
